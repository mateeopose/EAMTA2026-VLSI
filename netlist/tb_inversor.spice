** sch_path: /foss/designs/EAMTA2026-VLSI/verification/testbenches/tb_inversor.sch
**.subckt tb_inversor
x1 net2 vout vin net3 inversor
x2 net2 net1 vout net3 inversor
V4 net3 0 DC{Vss}
V5 net2 net3 DC{Vdd}
V6 vin net3 PULSE({Vdd} 0 0.0 1p 1p {Tclk/4} {Tclk/2}) DC 0 AC 0
C1 net1 net3 1p
**** begin user architecture code

* Circuit Parameters
.param vdd = 1.2
.param vss = 0.0
.param Tclk = 10n
.options TEMP = 27.0
* Include Models - IHP SG13G2
.lib cornerMOSlv.lib mos_tt
* OP Parameters & Singals to save
.save all
*Simulations
.control
tran 0.01u 100n
setplot tran1
plot v(vin) v(vout)+1.2
reset
dc V6 0 1.2 0.01
setplot dc
plot vin vout ylabel vout xlabel vin
set filetype = ascii
write dcsweep.raw
.endc
.end

**** end user architecture code
**.ends

* expanding   symbol:  blocks/inversor/schematic/inversor.sym # of pins=4
** sym_path: /foss/designs/EAMTA2026-VLSI/design/blocks/inversor/schematic/inversor.sym
** sch_path: /foss/designs/EAMTA2026-VLSI/design/blocks/inversor/schematic/inversor.sch
.subckt inversor Vdd out in Vss
*.iopin out
*.iopin Vdd
*.iopin Vss
*.iopin in
XM3 out in Vdd Vdd sg13_lv_pmos w=0.45u l=0.15u ng=1
XM1 out in Vss Vss sg13_lv_nmos w=0.15u l=0.45u ng=1
.ends

.end
